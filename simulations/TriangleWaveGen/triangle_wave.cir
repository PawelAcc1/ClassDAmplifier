TRAINGLE WAVE GENERATOR FOR CLASS D AMPLIFIER
*******************************
*LIBRARIES
.LIB "tlv9062.lib" ;OPAMP LIB
.LIB "tlv3201.lib"

*SOURCES
V_CC VCC 0 DC 5 ;AMPS POWER SUPPLY
V_REF VREF 0 DC 2.5 ;VREF DC OFFSET

*RESISTORS
R1 SCHMITT_OUT IN_N1 2.5K
R2 INT_OUT IN_P2 10K
R3 IN_P2 SCHMITT_OUT 25K

*CAPCITOR
C1 IN_N1 INT_OUT 1N

*OPAMPS
X_INTEGRATOR VREF IN_N1 VCC 0 INT_OUT TLV9062 ;INTEGRATOR
X_SCHMITT IN_P2 VREF VCC 0 SCHMITT_OUT TLV3201 ;SCHMITT FLIP FLOP

*DIRECTIVES
.TRAN 0.1N 20U
*.PROBE
.END
